| / 7\'7   Xilinx XC9500 I/O Buffer IBIS File
| \ \   Xilinx Inc.
| / /   2100 Logic Drive
| \_\/.\   San Jose,   CA 95124
[IBIS ver]   2.1
[File name]   xc9500.ibs
[File Rev]   1.2
[Date]   June 15, 1999
[Source]   Spice netlist
[Notes]   - max/min process data is not included in this ibis model
   - Control flag setting:
   SLW=0 - fast slew rate
   SLW=1 - slow slew rate
   VIO=0 - 3.3V Vddio
   VIO=1 - 5.0V Vddio
   - Created by Joey Jia x4437
[Disclaimer] The data in this model is derived from SPICE simulations
                 using modeling information extracted from the target pro-
                 cess. While a great deal of care has been take to provide
                 information that is accurate, this model is considered
                 preliminary as it has not been verified by actual silicon
                 measurement. Treat the data in this model as preliminary
                 until actual silicon verification is performed.
[Copyright]   Xilinx Inc.
|   Component XC9536_PLCC44[SLW=0;VIO=0]
[Component]   comp
[Manufacturer]   Xilinx Inc.
[Package]
| variable   typ   min   max
R_pkg   67.500m   66.000m   69.000m
L_pkg   3.910nH   3.550nH   4.260nH
C_pkg   0.895pF   0.790pF   1.000pF
[Pin]  signal_name   model_name   R_pin   L_pin   C_pin
M26   iob   IO_00   NA   NA   NA
[Component]   XC9536_PLCC44[SLW=0;VIO=0]
[Manufacturer]   Xilinx Inc.
[Package]
| variable   typ   min   max
R_pkg   67.500m   66.000m   69.000m
L_pkg   3.910nH   3.550nH   4.260nH
C_pkg   0.895pF   0.790pF   1.000pF
[Pin]  signal_name   model_name   R_pin   L_pin   C_pin
io   iob   IO_00   NA   NA   NA
|   Component XC9536_PLCC44[SLW=1;VIO=0]
[Component]   XC9536_PLCC44[SLW=1;VIO=0]
[Manufacturer]   Xilinx Inc.
[Package]
| variable   typ   min   max
R_pkg   67.500m   66.000m   69.000m
L_pkg   3.910nH   3.550nH   4.260nH
C_pkg   0.895pF   0.790pF   1.000pF
[Pin]  signal_name   model_name   R_pin   L_pin   C_pin
io   iob   IO_10   NA   NA   NA
|   Component XC9536_PLCC44[SLW=0;VIO=1]
[Component]   XC9536_PLCC44[SLW=0;VIO=1]
[Manufacturer]   Xilinx Inc.
[Package]
| variable   typ   min   max
R_pkg   67.500m   66.000m   69.000m
L_pkg   3.910nH   3.550nH   4.260nH
C_pkg   0.895pF   0.790pF   1.000pF
[Pin]  signal_name   model_name   R_pin   L_pin   C_pin
io   iob   IO_01   NA   NA   NA
|   Component XC9536_PLCC44[SLW=1;VIO=1]
[Component]   XC9536_PLCC44[SLW=1;VIO=1]
[Manufacturer]   Xilinx Inc.
[Package]
| variable   typ   min   max
R_pkg   67.500m   66.000m   69.000m
L_pkg   3.910nH   3.550nH   4.260nH
C_pkg   0.895pF   0.790pF   1.000pF
[Pin]  signal_name   model_name   R_pin   L_pin   C_pin
io   iob   IO_11   NA   NA   NA
|   Component XC9536_VQ44[SLW=0;VIO=0]
[Component]   XC9536_VQ44[SLW=0;VIO=0]
[Manufacturer]   Xilinx Inc.
[Package]
| variable   typ   min   max
R_pkg   57.000m   54.000m   60.000m
L_pkg   2.270nH   2.100nH   2.430nH
C_pkg   0.275pF   0.260pF   0.290pF
[Pin]  signal_name   model_name   R_pin   L_pin   C_pin
io   iob   IO_00   NA   NA   NA
| End [Component] XC9536_VQ44[SLW=0;VIO=0]
|   Component XC9536_VQ44[SLW=0;VIO=1]
[Component]   XC9536_VQ44[SLW=0;VIO=1]
[Manufacturer]   Xilinx Inc.
[Package]
| variable   typ   min   max
R_pkg   57.000m   54.000m   60.000m
L_pkg   2.270nH   2.100nH   2.430nH
C_pkg   0.275pF   0.260pF   0.290pF
[Pin]  signal_name   model_name   R_pin   L_pin   C_pin
io   iob   IO_01   NA   NA   NA
| End [Component] XC9536_VQ44[SLW=0;VIO=1]
|   Component XC9536_VQ44[SLW=1;VIO=0]
[Component]   XC9536_VQ44[SLW=1;VIO=0]
[Manufacturer]   Xilinx Inc.
[Package]
| variable   typ   min   max
R_pkg   57.000m   54.000m   60.000m
L_pkg   2.270nH   2.100nH   2.430nH
C_pkg   0.275pF   0.260pF   0.290pF
[Pin]  signal_name   model_name   R_pin   L_pin   C_pin
io   iob   IO_10   NA   NA   NA
| End [Component] XC9536_VQ44[SLW=1;VIO=0]
|   Component XC9536_VQ44[SLW=1;VIO=1]
[Component]   XC9536_VQ44[SLW=1;VIO=1]
[Manufacturer]   Xilinx Inc.
[Package]
| variable   typ   min   max
R_pkg   57.000m   54.000m   60.000m
L_pkg   2.270nH   2.100nH   2.430nH
C_pkg   0.275pF   0.260pF   0.290pF
[Pin]  signal_name   model_name   R_pin   L_pin   C_pin
io   iob   IO_11   NA   NA   NA
| End [Component] XC9536_VQ44[SLW=1;VIO=1]
|   Component XC9572_PLCC44[SLW=0;VIO=0]
[Component]   XC9572_PLCC44[SLW=0;VIO=0]
[Manufacturer]   Xilinx Inc.
[Package]
| variable   typ   min   max
R_pkg   67.500m   66.000m   69.000m
L_pkg   3.910nH   3.550nH   4.260nH
C_pkg   0.895pF   0.790pF   1.000pF
[Pin]  signal_name   model_name   R_pin   L_pin   C_pin
io   iob   IO_00   NA   NA   NA
| End [Component] XC9572_PLCC44[SLW=0;VIO=0]
|   Component XC9572_PLCC44[SLW=0;VIO=1]
[Component]   XC9572_PLCC44[SLW=0;VIO=1]
[Manufacturer]   Xilinx Inc.
[Package]
| variable   typ   min   max
R_pkg   67.500m   66.000m   69.000m
L_pkg   3.910nH   3.550nH   4.260nH
C_pkg   0.895pF   0.790pF   1.000pF
[Pin]  signal_name   model_name   R_pin   L_pin   C_pin
io   iob   IO_01   NA   NA   NA
| End [Component] XC9572_PLCC44[SLW=0;VIO=1]
|   Component XC9572_PLCC44[SLW=1;VIO=0]
[Component]   XC9572_PLCC44[SLW=1;VIO=0]
[Manufacturer]   Xilinx Inc.
[Package]
| variable   typ   min   max
R_pkg   67.500m   66.000m   69.000m
L_pkg   3.910nH   3.550nH   4.260nH
C_pkg   0.895pF   0.790pF   1.000pF
[Pin]  signal_name   model_name   R_pin   L_pin   C_pin
io   iob   IO_10   NA   NA   NA
| End [Component] XC9572_PLCC44[SLW=1;VIO=0]
|   Component XC9572_PLCC44[SLW=1;VIO=1]
[Component]   XC9572_PLCC44[SLW=1;VIO=1]
[Manufacturer]   Xilinx Inc.
[Package]
| variable   typ   min   max
R_pkg   67.500m   66.000m   69.000m
L_pkg   3.910nH   3.550nH   4.260nH
C_pkg   0.895pF   0.790pF   1.000pF
[Pin]  signal_name   model_name   R_pin   L_pin   C_pin
io   iob   IO_11   NA   NA   NA
| End [Component] XC9572_PLCC44[SLW=1;VIO=1]
|   Component XC9572_PLCC84[SLW=0;VIO=0]
[Component]   XC9572_PLCC84[SLW=0;VIO=0]
[Manufacturer]   Xilinx Inc.
[Package]
| variable   typ   min   max
R_pkg   0.104   97.000m   0.111
L_pkg   11.600nH   10.200nH   13.000nH
C_pkg   1.700pF   1.600pF   1.800pF
[Pin]  signal_name   model_name   R_pin   L_pin   C_pin
io   iob   IO_00   NA   NA   NA
| End [Component] XC9572_PLCC84[SLW=0;VIO=0]
|   Component XC9572_PLCC84[SLW=0;VIO=1]
[Component]   XC9572_PLCC84[SLW=0;VIO=1]
[Manufacturer]   Xilinx Inc.
[Package]
| variable   typ   min   max
R_pkg   0.104   97.000m   0.111
L_pkg   11.600nH   10.200nH   13.000nH
C_pkg   1.700pF   1.600pF   1.800pF
[Pin]  signal_name   model_name   R_pin   L_pin   C_pin
io   iob   IO_01   NA   NA   NA
| End [Component] XC9572_PLCC84[SLW=0;VIO=1]
|   Component XC9572_PLCC84[SLW=1;VIO=0]
[Component]   XC9572_PLCC84[SLW=1;VIO=0]
[Manufacturer]   Xilinx Inc.
[Package]
| variable   typ   min   max
R_pkg   0.104   97.000m   0.111
L_pkg   11.600nH   10.200nH   13.000nH
C_pkg   1.700pF   1.600pF   1.800pF
[Pin]  signal_name   model_name   R_pin   L_pin   C_pin
io   iob   IO_10   NA   NA   NA
| End [Component] XC9572_PLCC84[SLW=1;VIO=0]
|   Component XC9572_PLCC84[SLW=1;VIO=1]
[Component]   XC9572_PLCC84[SLW=1;VIO=1]
[Manufacturer]   Xilinx Inc.
[Package]
| variable   typ   min   max
R_pkg   0.104   97.000m   0.111
L_pkg   11.600nH   10.200nH   13.000nH
C_pkg   1.700pF   1.600pF   1.800pF
[Pin]  signal_name   model_name   R_pin   L_pin   C_pin
io   iob   IO_11   NA   NA   NA
| End [Component] XC9572_PLCC84[SLW=1;VIO=1]
|   Component XC9572_PQ100[SLW=0;VIO=0]
[Component]   XC9572_PQ100[SLW=0;VIO=0]
[Manufacturer]   Xilinx Inc.
[Package]
| variable   typ   min   max
R_pkg   88.000m   78.000m   98.000m
L_pkg   6.100nH   4.100nH   8.100nH
C_pkg   0.900pF   0.700pF   1.100pF
[Pin]  signal_name   model_name   R_pin   L_pin   C_pin
io   iob   IO_00   NA   NA   NA
| End [Component] XC9572_PQ100[SLW=0;VIO=0]
|   Component XC9572_PQ100[SLW=0;VIO=1]
[Component]   XC9572_PQ100[SLW=0;VIO=1]
[Manufacturer]   Xilinx Inc.
[Package]
| variable   typ   min   max
R_pkg   88.000m   78.000m   98.000m
L_pkg   6.100nH   4.100nH   8.100nH
C_pkg   0.900pF   0.700pF   1.100pF
[Pin]  signal_name   model_name   R_pin   L_pin   C_pin
io   iob   IO_01   NA   NA   NA
| End [Component] XC9572_PQ100[SLW=0;VIO=1]
|   Component XC9572_PQ100[SLW=1;VIO=0]
[Component]   XC9572_PQ100[SLW=1;VIO=0]
[Manufacturer]   Xilinx Inc.
[Package]
| variable   typ   min   max
R_pkg   88.000m   78.000m   98.000m
L_pkg   6.100nH   4.100nH   8.100nH
C_pkg   0.900pF   0.700pF   1.100pF
[Pin]  signal_name   model_name   R_pin   L_pin   C_pin
io   iob   IO_10   NA   NA   NA
| End [Component] XC9572_PQ100[SLW=1;VIO=0]
|   Component XC9572_PQ100[SLW=1;VIO=1]
[Component]   XC9572_PQ100[SLW=1;VIO=1]
[Manufacturer]   Xilinx Inc.
[Package]
| variable   typ   min   max
R_pkg   88.000m   78.000m   98.000m
L_pkg   6.100nH   4.100nH   8.100nH
C_pkg   0.900pF   0.700pF   1.100pF
[Pin]  signal_name   model_name   R_pin   L_pin   C_pin
io   iob   IO_11   NA   NA   NA
| End [Component] XC9572_PQ100[SLW=1;VIO=1]
|   Component XC9572_TQ100[SLW=0;VIO=0]
[Component]   XC9572_TQ100[SLW=0;VIO=0]
[Manufacturer]   Xilinx Inc.
[Package]
| variable   typ   min   max
R_pkg   84.500m   79.000m   90.000m
L_pkg   4.370nH   3.820nH   4.920nH
C_pkg   0.610pF   0.570pF   0.650pF
[Pin]  signal_name   model_name   R_pin   L_pin   C_pin
io   iob   IO_00   NA   NA   NA
| End [Component] XC9572_TQ100[SLW=0;VIO=0]
|   Component XC9572_TQ100[SLW=0;VIO=1]
[Component]   XC9572_TQ100[SLW=0;VIO=1]
[Manufacturer]   Xilinx Inc.
[Package]
| variable   typ   min   max
R_pkg   84.500m   79.000m   90.000m
L_pkg   4.370nH   3.820nH   4.920nH
C_pkg   0.610pF   0.570pF   0.650pF
[Pin]  signal_name   model_name   R_pin   L_pin   C_pin
io   iob   IO_01   NA   NA   NA
| End [Component] XC9572_TQ100[SLW=0;VIO=1]
|   Component XC9572_TQ100[SLW=1;VIO=0]
[Component]   XC9572_TQ100[SLW=1;VIO=0]
[Manufacturer]   Xilinx Inc.
[Package]
| variable   typ   min   max
R_pkg   84.500m   79.000m   90.000m
L_pkg   4.370nH   3.820nH   4.920nH
C_pkg   0.610pF   0.570pF   0.650pF
[Pin]  signal_name   model_name   R_pin   L_pin   C_pin
io   iob   IO_10   NA   NA   NA
| End [Component] XC9572_TQ100[SLW=1;VIO=0]
|   Component XC9572_TQ100[SLW=1;VIO=1]
[Component]   XC9572_TQ100[SLW=1;VIO=1]
[Manufacturer]   Xilinx Inc.
[Package]
| variable   typ   min   max
R_pkg   84.500m   79.000m   90.000m
L_pkg   4.370nH   3.820nH   4.920nH
C_pkg   0.610pF   0.570pF   0.650pF
[Pin]  signal_name   model_name   R_pin   L_pin   C_pin
io   iob   IO_11   NA   NA   NA
| End [Component] XC9572_TQ100[SLW=1;VIO=1]
|   Component XC95108_PLCC84[SLW=0;VIO=0]
[Component]   XC95108_PLCC84[SLW=0;VIO=0]
[Manufacturer]   Xilinx Inc.
[Package]
| variable   typ   min   max
R_pkg   0.104   97.000m   0.111
L_pkg   11.600nH   10.200nH   13.000nH
C_pkg   1.700pF   1.600pF   1.800pF
[Pin]  signal_name   model_name   R_pin   L_pin   C_pin
io   iob   IO_00   NA   NA   NA
| End [Component] XC95108_PLCC84[SLW=0;VIO=0]
|   Component XC95108_PLCC84[SLW=0;VIO=1]
[Component]   XC95108_PLCC84[SLW=0;VIO=1]
[Manufacturer]   Xilinx Inc.
[Package]
| variable   typ   min   max
R_pkg   0.104   97.000m   0.111
L_pkg   11.600nH   10.200nH   13.000nH
C_pkg   1.700pF   1.600pF   1.800pF
[Pin]  signal_name   model_name   R_pin   L_pin   C_pin
io   iob   IO_01   NA   NA   NA
| End [Component] XC95108_PLCC84[SLW=0;VIO=1]
|   Component XC95108_PLCC84[SLW=1;VIO=0]
[Component]   XC95108_PLCC84[SLW=1;VIO=0]
[Manufacturer]   Xilinx Inc.
[Package]
| variable   typ   min   max
R_pkg   0.104   97.000m   0.111
L_pkg   11.600nH   10.200nH   13.000nH
C_pkg   1.700pF   1.600pF   1.800pF
[Pin]  signal_name   model_name   R_pin   L_pin   C_pin
io   iob   IO_10   NA   NA   NA
| End [Component] XC95108_PLCC84[SLW=1;VIO=0]
|   Component XC95108_PLCC84[SLW=1;VIO=1]
[Component]   XC95108_PLCC84[SLW=1;VIO=1]
[Manufacturer]   Xilinx Inc.
[Package]
| variable   typ   min   max
R_pkg   0.104   97.000m   0.111
L_pkg   11.600nH   10.200nH   13.000nH
C_pkg   1.700pF   1.600pF   1.800pF
[Pin]  signal_name   model_name   R_pin   L_pin   C_pin
io   iob   IO_11   NA   NA   NA
| End [Component] XC95108_PLCC84[SLW=1;VIO=1]
|   Component XC95108_PQ100[SLW=0;VIO=0]
[Component]   XC95108_PQ100[SLW=0;VIO=0]
[Manufacturer]   Xilinx Inc.
[Package]
| variable   typ   min   max
R_pkg   88.000m   78.000m   98.000m
L_pkg   6.100nH   4.100nH   8.100nH
C_pkg   0.900pF   0.700pF   1.100pF
[Pin]  signal_name   model_name   R_pin   L_pin   C_pin
io   iob   IO_00   NA   NA   NA
| End [Component] XC95108_PQ100[SLW=0;VIO=0]
|   Component XC95108_PQ100[SLW=0;VIO=1]
[Component]   XC95108_PQ100[SLW=0;VIO=1]
[Manufacturer]   Xilinx Inc.
[Package]
| variable   typ   min   max
R_pkg   88.000m   78.000m   98.000m
L_pkg   6.100nH   4.100nH   8.100nH
C_pkg   0.900pF   0.700pF   1.100pF
[Pin]  signal_name   model_name   R_pin   L_pin   C_pin
io   iob   IO_01   NA   NA   NA
| End [Component] XC95108_PQ100[SLW=0;VIO=1]
|   Component XC95108_PQ100[SLW=1;VIO=0]
[Component]   XC95108_PQ100[SLW=1;VIO=0]
[Manufacturer]   Xilinx Inc.
[Package]
| variable   typ   min   max
R_pkg   88.000m   78.000m   98.000m
L_pkg   6.100nH   4.100nH   8.100nH
C_pkg   0.900pF   0.700pF   1.100pF
[Pin]  signal_name   model_name   R_pin   L_pin   C_pin
io   iob   IO_10   NA   NA   NA
| End [Component] XC95108_PQ100[SLW=1;VIO=0]
|   Component XC95108_PQ100[SLW=1;VIO=1]
[Component]   XC95108_PQ100[SLW=1;VIO=1]
[Manufacturer]   Xilinx Inc.
[Package]
| variable   typ   min   max
R_pkg   88.000m   78.000m   98.000m
L_pkg   6.100nH   4.100nH   8.100nH
C_pkg   0.900pF   0.700pF   1.100pF
[Pin]  signal_name   model_name   R_pin   L_pin   C_pin
io   iob   IO_11   NA   NA   NA
| End [Component] XC95108_PQ100[SLW=1;VIO=1]
|   Component XC95108_PQ160[SLW=0;VIO=0]
[Component]   XC95108_PQ160[SLW=0;VIO=0]
[Manufacturer]   Xilinx Inc.
[Package]
| variable   typ   min   max
R_pkg   0.194   0.181   0.207
L_pkg   13.300nH   11.300nH   15.200nH
C_pkg   1.700pF   1.500pF   1.900pF
[Pin]  signal_name   model_name   R_pin   L_pin   C_pin
io   iob   IO_00   NA   NA   NA
| End [Component] XC95108_PQ160[SLW=0;VIO=0]
|   Component XC95108_PQ160[SLW=0;VIO=1]
[Component]   XC95108_PQ160[SLW=0;VIO=1]
[Manufacturer]   Xilinx Inc.
[Package]
| variable   typ   min   max
R_pkg   0.194   0.181   0.207
L_pkg   13.300nH   11.300nH   15.200nH
C_pkg   1.700pF   1.500pF   1.900pF
[Pin]  signal_name   model_name   R_pin   L_pin   C_pin
io   iob   IO_01   NA   NA   NA
| End [Component] XC95108_PQ160[SLW=0;VIO=1]
|   Component XC95108_PQ160[SLW=1;VIO=0]
[Component]   XC95108_PQ160[SLW=1;VIO=0]
[Manufacturer]   Xilinx Inc.
[Package]
| variable   typ   min   max
R_pkg   0.194   0.181   0.207
L_pkg   13.300nH   11.300nH   15.200nH
C_pkg   1.700pF   1.500pF   1.900pF
[Pin]  signal_name   model_name   R_pin   L_pin   C_pin
io   iob   IO_10   NA   NA   NA
| End [Component] XC95108_PQ160[SLW=1;VIO=0]
|   Component XC95108_PQ160[SLW=1;VIO=1]
[Component]   XC95108_PQ160[SLW=1;VIO=1]
[Manufacturer]   Xilinx Inc.
[Package]
| variable   typ   min   max
R_pkg   0.194   0.181   0.207
L_pkg   13.300nH   11.300nH   15.200nH
C_pkg   1.700pF   1.500pF   1.900pF
[Pin]  signal_name   model_name   R_pin   L_pin   C_pin
io   iob   IO_11   NA   NA   NA
| End [Component] XC95108_PQ160[SLW=1;VIO=1]
|   Component XC95108_TQ100[SLW=0;VIO=0]
[Component]   XC95108_TQ100[SLW=0;VIO=0]
[Manufacturer]   Xilinx Inc.
[Package]
| variable   typ   min   max
R_pkg   84.500m   79.000m   90.000m
L_pkg   4.370nH   3.820nH   4.920nH
C_pkg   0.610pF   0.570pF   0.650pF
[Pin]  signal_name   model_name   R_pin   L_pin   C_pin
io   iob   IO_00   NA   NA   NA
| End [Component] XC95108_TQ100[SLW=0;VIO=0]
|   Component XC95108_TQ100[SLW=0;VIO=1]
[Component]   XC95108_TQ100[SLW=0;VIO=1]
[Manufacturer]   Xilinx Inc.
[Package]
| variable   typ   min   max
R_pkg   84.500m   79.000m   90.000m
L_pkg   4.370nH   3.820nH   4.920nH
C_pkg   0.610pF   0.570pF   0.650pF
[Pin]  signal_name   model_name   R_pin   L_pin   C_pin
io   iob   IO_01   NA   NA   NA
| End [Component] XC95108_TQ100[SLW=0;VIO=1]
|   Component XC95108_TQ100[SLW=1;VIO=0]
[Component]   XC95108_TQ100[SLW=1;VIO=0]
[Manufacturer]   Xilinx Inc.
[Package]
| variable   typ   min   max
R_pkg   84.500m   79.000m   90.000m
L_pkg   4.370nH   3.820nH   4.920nH
C_pkg   0.610pF   0.570pF   0.650pF
[Pin]  signal_name   model_name   R_pin   L_pin   C_pin
io   iob   IO_10   NA   NA   NA
| End [Component] XC95108_TQ100[SLW=1;VIO=0]
|   Component XC95108_TQ100[SLW=1;VIO=1]
[Component]   XC95108_TQ100[SLW=1;VIO=1]
[Manufacturer]   Xilinx Inc.
[Package]
| variable   typ   min   max
R_pkg   84.500m   79.000m   90.000m
L_pkg   4.370nH   3.820nH   4.920nH
C_pkg   0.610pF   0.570pF   0.650pF
[Pin]  signal_name   model_name   R_pin   L_pin   C_pin
io   iob   IO_11   NA   NA   NA
| End [Component] XC95108_TQ100[SLW=1;VIO=1]
|   Component XC95144_PQ100[SLW=0;VIO=0]
[Component]   XC95144_PQ100[SLW=0;VIO=0]
[Manufacturer]   Xilinx Inc.
[Package]
| variable   typ   min   max
R_pkg   88.000m   78.000m   98.000m
L_pkg   6.100nH   4.100nH   8.100nH
C_pkg   0.900pF   0.700pF   1.100pF
[Pin]  signal_name   model_name   R_pin   L_pin   C_pin
io   iob   IO_00   NA   NA   NA
| End [Component] XC95144_PQ100[SLW=0;VIO=0]
|   Component XC95144_PQ100[SLW=0;VIO=1]
[Component]   XC95144_PQ100[SLW=0;VIO=1]
[Manufacturer]   Xilinx Inc.
[Package]
| variable   typ   min   max
R_pkg   88.000m   78.000m   98.000m
L_pkg   6.100nH   4.100nH   8.100nH
C_pkg   0.900pF   0.700pF   1.100pF
[Pin]  signal_name   model_name   R_pin   L_pin   C_pin
io   iob   IO_01   NA   NA   NA
| End [Component] XC95144_PQ100[SLW=0;VIO=1]
|   Component XC95144_PQ100[SLW=1;VIO=0]
[Component]   XC95144_PQ100[SLW=1;VIO=0]
[Manufacturer]   Xilinx Inc.
[Package]
| variable   typ   min   max
R_pkg   88.000m   78.000m   98.000m
L_pkg   6.100nH   4.100nH   8.100nH
C_pkg   0.900pF   0.700pF   1.100pF
[Pin]  signal_name   model_name   R_pin   L_pin   C_pin
io   iob   IO_10   NA   NA   NA
| End [Component] XC95144_PQ100[SLW=1;VIO=0]
|   Component XC95144_PQ100[SLW=1;VIO=1]
[Component]   XC95144_PQ100[SLW=1;VIO=1]
[Manufacturer]   Xilinx Inc.
[Package]
| variable   typ   min   max
R_pkg   88.000m   78.000m   98.000m
L_pkg   6.100nH   4.100nH   8.100nH
C_pkg   0.900pF   0.700pF   1.100pF
[Pin]  signal_name   model_name   R_pin   L_pin   C_pin
io   iob   IO_11   NA   NA   NA
| End [Component] XC95144_PQ100[SLW=1;VIO=1]
|   Component XC95144_PQ160[SLW=0;VIO=0]
[Component]   XC95144_PQ160[SLW=0;VIO=0]
[Manufacturer]   Xilinx Inc.
[Package]
| variable   typ   min   max
R_pkg   0.194   0.181   0.207
L_pkg   13.300nH   11.300nH   15.200nH
C_pkg   1.700pF   1.500pF   1.900pF
[Pin]  signal_name   model_name   R_pin   L_pin   C_pin
io   iob   IO_00   NA   NA   NA
| End [Component] XC95144_PQ160[SLW=0;VIO=0]
|   Component XC95144_PQ160[SLW=0;VIO=1]
[Component]   XC95144_PQ160[SLW=0;VIO=1]
[Manufacturer]   Xilinx Inc.
[Package]
| variable   typ   min   max
R_pkg   0.194   0.181   0.207
L_pkg   13.300nH   11.300nH   15.200nH
C_pkg   1.700pF   1.500pF   1.900pF
[Pin]  signal_name   model_name   R_pin   L_pin   C_pin
io   iob   IO_01   NA   NA   NA
| End [Component] XC95144_PQ160[SLW=0;VIO=1]
|   Component XC95144_PQ160[SLW=1;VIO=0]
[Component]   XC95144_PQ160[SLW=1;VIO=0]
[Manufacturer]   Xilinx Inc.
[Package]
| variable   typ   min   max
R_pkg   0.194   0.181   0.207
L_pkg   13.300nH   11.300nH   15.200nH
C_pkg   1.700pF   1.500pF   1.900pF
[Pin]  signal_name   model_name   R_pin   L_pin   C_pin
io   iob   IO_10   NA   NA   NA
| End [Component] XC95144_PQ160[SLW=1;VIO=0]
|   Component XC95144_PQ160[SLW=1;VIO=1]
[Component]   XC95144_PQ160[SLW=1;VIO=1]
[Manufacturer]   Xilinx Inc.
[Package]
| variable   typ   min   max
R_pkg   0.194   0.181   0.207
L_pkg   13.300nH   11.300nH   15.200nH
C_pkg   1.700pF   1.500pF   1.900pF
[Pin]  signal_name   model_name   R_pin   L_pin   C_pin
io   iob   IO_11   NA   NA   NA
| End [Component] XC95144_PQ160[SLW=1;VIO=1]
|   Component XC95144_TQ100[SLW=0;VIO=0]
[Component]   XC95144_TQ100[SLW=0;VIO=0]
[Manufacturer]   Xilinx Inc.
[Package]
| variable   typ   min   max
R_pkg   89.500m   84.000m   95.000m
L_pkg   5.200nH   4.700nH   5.700nH
C_pkg   0.650pF   0.600pF   0.700pF
[Pin]  signal_name   model_name   R_pin   L_pin   C_pin
io   iob   IO_00   NA   NA   NA
| End [Component] XC95144_TQ100[SLW=0;VIO=0]
|   Component XC95144_TQ100[SLW=0;VIO=1]
[Component]   XC95144_TQ100[SLW=0;VIO=1]
[Manufacturer]   Xilinx Inc.
[Package]
| variable   typ   min   max
R_pkg   89.500m   84.000m   95.000m
L_pkg   5.200nH   4.700nH   5.700nH
C_pkg   0.650pF   0.600pF   0.700pF
[Pin]  signal_name   model_name   R_pin   L_pin   C_pin
io   iob   IO_01   NA   NA   NA
| End [Component] XC95144_TQ100[SLW=0;VIO=1]
|   Component XC95144_TQ100[SLW=1;VIO=0]
[Component]   XC95144_TQ100[SLW=1;VIO=0]
[Manufacturer]   Xilinx Inc.
[Package]
| variable   typ   min   max
R_pkg   89.500m   84.000m   95.000m
L_pkg   5.200nH   4.700nH   5.700nH
C_pkg   0.650pF   0.600pF   0.700pF
[Pin]  signal_name   model_name   R_pin   L_pin   C_pin
io   iob   IO_10   NA   NA   NA
| End [Component] XC95144_TQ100[SLW=1;VIO=0]
|   Component XC95144_TQ100[SLW=1;VIO=1]
[Component]   XC95144_TQ100[SLW=1;VIO=1]
[Manufacturer]   Xilinx Inc.
[Package]
| variable   typ   min   max
R_pkg   89.500m   84.000m   95.000m
L_pkg   5.200nH   4.700nH   5.700nH
C_pkg   0.650pF   0.600pF   0.700pF
[Pin]  signal_name   model_name   R_pin   L_pin   C_pin
io   iob   IO_11   NA   NA   NA
| End [Component] XC95144_TQ100[SLW=1;VIO=1]
|   Component XC95216_BGA352[SLW=0;VIO=0]
[Component]   XC95216_BGA352[SLW=0;VIO=0]
[Manufacturer]   Xilinx Inc.
[Package]
| variable   typ   min   max
R_pkg   0.225   0.161   0.290
L_pkg   5.500nH   3.800nH   7.200nH
C_pkg   0.950pF   0.700pF   1.200pF
[Pin]  signal_name   model_name   R_pin   L_pin   C_pin
io   iob   IO_00   NA   NA   NA
| End [Component] XC95216_BGA352[SLW=0;VIO=0]
|   Component XC95216_BGA352[SLW=0;VIO=1]
[Component]   XC95216_BGA352[SLW=0;VIO=1]
[Manufacturer]   Xilinx Inc.
[Package]
| variable   typ   min   max
R_pkg   0.225   0.161   0.290
L_pkg   5.500nH   3.800nH   7.200nH
C_pkg   0.950pF   0.700pF   1.200pF
[Pin]  signal_name   model_name   R_pin   L_pin   C_pin
io   iob   IO_01   NA   NA   NA
| End [Component] XC95216_BGA352[SLW=0;VIO=1]
|   Component XC95216_BGA352[SLW=1;VIO=0]
[Component]   XC95216_BGA352[SLW=1;VIO=0]
[Manufacturer]   Xilinx Inc.
[Package]
| variable   typ   min   max
R_pkg   0.225   0.161   0.290
L_pkg   5.500nH   3.800nH   7.200nH
C_pkg   0.950pF   0.700pF   1.200pF
[Pin]  signal_name   model_name   R_pin   L_pin   C_pin
io   iob   IO_10   NA   NA   NA
| End [Component] XC95216_BGA352[SLW=1;VIO=0]
|   Component XC95216_BGA352[SLW=1;VIO=1]
[Component]   XC95216_BGA352[SLW=1;VIO=1]
[Manufacturer]   Xilinx Inc.
[Package]
| variable   typ   min   max
R_pkg   0.225   0.161   0.290
L_pkg   5.500nH   3.800nH   7.200nH
C_pkg   0.950pF   0.700pF   1.200pF
[Pin]  signal_name   model_name   R_pin   L_pin   C_pin
io   iob   IO_11   NA   NA   NA
| End [Component] XC95216_BGA352[SLW=1;VIO=1]
|   Component XC95216_HQ208[SLW=0;VIO=0]
[Component]   XC95216_HQ208[SLW=0;VIO=0]
[Manufacturer]   Xilinx Inc.
[Package]
| variable   typ   min   max
R_pkg   0.146   0.137   0.155
L_pkg   9.450nH   7.110nH   11.790nH
C_pkg   1.930pF   1.780pF   2.070pF
[Pin]  signal_name   model_name   R_pin   L_pin   C_pin
io   iob   IO_00   NA   NA   NA
| End [Component] XC95216_HQ208[SLW=0;VIO=0]
|   Component XC95216_HQ208[SLW=0;VIO=1]
[Component]   XC95216_HQ208[SLW=0;VIO=1]
[Manufacturer]   Xilinx Inc.
[Package]
| variable   typ   min   max
R_pkg   0.146   0.137   0.155
L_pkg   9.450nH   7.110nH   11.790nH
C_pkg   1.930pF   1.780pF   2.070pF
[Pin]  signal_name   model_name   R_pin   L_pin   C_pin
io   iob   IO_01   NA   NA   NA
| End [Component] XC95216_HQ208[SLW=0;VIO=1]
|   Component XC95216_HQ208[SLW=1;VIO=0]
[Component]   XC95216_HQ208[SLW=1;VIO=0]
[Manufacturer]   Xilinx Inc.
[Package]
| variable   typ   min   max
R_pkg   0.146   0.137   0.155
L_pkg   9.450nH   7.110nH   11.790nH
C_pkg   1.930pF   1.780pF   2.070pF
[Pin]  signal_name   model_name   R_pin   L_pin   C_pin
io   iob   IO_10   NA   NA   NA
| End [Component] XC95216_HQ208[SLW=1;VIO=0]
|   Component XC95216_HQ208[SLW=1;VIO=1]
[Component]   XC95216_HQ208[SLW=1;VIO=1]
[Manufacturer]   Xilinx Inc.
[Package]
| variable   typ   min   max
R_pkg   0.146   0.137   0.155
L_pkg   9.450nH   7.110nH   11.790nH
C_pkg   1.930pF   1.780pF   2.070pF
[Pin]  signal_name   model_name   R_pin   L_pin   C_pin
io   iob   IO_11   NA   NA   NA
| End [Component] XC95216_HQ208[SLW=1;VIO=1]
|   Component XC95216_PQ160[SLW=0;VIO=0]
[Component]   XC95216_PQ160[SLW=0;VIO=0]
[Manufacturer]   Xilinx Inc.
[Package]
| variable   typ   min   max
R_pkg   0.172   0.159   0.186
L_pkg   12.450nH   10.700nH   14.200nH
C_pkg   1.450pF   1.300pF   1.600pF
[Pin]  signal_name   model_name   R_pin   L_pin   C_pin
io   iob   IO_00   NA   NA   NA
| End [Component] XC95216_PQ160[SLW=0;VIO=0]
|   Component XC95216_PQ160[SLW=0;VIO=1]
[Component]   XC95216_PQ160[SLW=0;VIO=1]
[Manufacturer]   Xilinx Inc.
[Package]
| variable   typ   min   max
R_pkg   0.172   0.159   0.186
L_pkg   12.450nH   10.700nH   14.200nH
C_pkg   1.450pF   1.300pF   1.600pF
[Pin]  signal_name   model_name   R_pin   L_pin   C_pin
io   iob   IO_01   NA   NA   NA
| End [Component] XC95216_PQ160[SLW=0;VIO=1]
|   Component XC95216_PQ160[SLW=1;VIO=0]
[Component]   XC95216_PQ160[SLW=1;VIO=0]
[Manufacturer]   Xilinx Inc.
[Package]
| variable   typ   min   max
R_pkg   0.172   0.159   0.186
L_pkg   12.450nH   10.700nH   14.200nH
C_pkg   1.450pF   1.300pF   1.600pF
[Pin]  signal_name   model_name   R_pin   L_pin   C_pin
io   iob   IO_10   NA   NA   NA
| End [Component] XC95216_PQ160[SLW=1;VIO=0]
|   Component XC95216_PQ160[SLW=1;VIO=1]
[Component]   XC95216_PQ160[SLW=1;VIO=1]
[Manufacturer]   Xilinx Inc.
[Package]
| variable   typ   min   max
R_pkg   0.172   0.159   0.186
L_pkg   12.450nH   10.700nH   14.200nH
C_pkg   1.450pF   1.300pF   1.600pF
[Pin]  signal_name   model_name   R_pin   L_pin   C_pin
io   iob   IO_11   NA   NA   NA
| End [Component] XC95216_PQ160[SLW=1;VIO=1]
|   Component XC95288_BGA352[SLW=0;VIO=0]
[Component]   XC95288_BGA352[SLW=0;VIO=0]
[Manufacturer]   Xilinx Inc.
[Package]
| variable   typ   min   max
R_pkg   0.225   0.161   0.290
L_pkg   5.500nH   3.800nH   7.200nH
C_pkg   0.950pF   0.700pF   1.200pF
[Pin]  signal_name   model_name   R_pin   L_pin   C_pin
io   iob   IO_00   NA   NA   NA
| End [Component] XC95288_BGA352[SLW=0;VIO=0]
|   Component XC95288_BGA352[SLW=0;VIO=1]
[Component]   XC95288_BGA352[SLW=0;VIO=1]
[Manufacturer]   Xilinx Inc.
[Package]
| variable   typ   min   max
R_pkg   0.225   0.161   0.290
L_pkg   5.500nH   3.800nH   7.200nH
C_pkg   0.950pF   0.700pF   1.200pF
[Pin]  signal_name   model_name   R_pin   L_pin   C_pin
io   iob   IO_01   NA   NA   NA
| End [Component] XC95288_BGA352[SLW=0;VIO=1]
|   Component XC95288_BGA352[SLW=1;VIO=0]
[Component]   XC95288_BGA352[SLW=1;VIO=0]
[Manufacturer]   Xilinx Inc.
[Package]
| variable   typ   min   max
R_pkg   0.225   0.161   0.290
L_pkg   5.500nH   3.800nH   7.200nH
C_pkg   0.950pF   0.700pF   1.200pF
[Pin]  signal_name   model_name   R_pin   L_pin   C_pin
io   iob   IO_10   NA   NA   NA
| End [Component] XC95288_BGA352[SLW=1;VIO=0]
|   Component XC95288_BGA352[SLW=1;VIO=1]
[Component]   XC95288_BGA352[SLW=1;VIO=1]
[Manufacturer]   Xilinx Inc.
[Package]
| variable   typ   min   max
R_pkg   0.225   0.161   0.290
L_pkg   5.500nH   3.800nH   7.200nH
C_pkg   0.950pF   0.700pF   1.200pF
[Pin]  signal_name   model_name   R_pin   L_pin   C_pin
io   iob   IO_11   NA   NA   NA
| End [Component] XC95288_BGA352[SLW=1;VIO=1]
|   Component XC95288_HQ208[SLW=0;VIO=0]
[Component]   XC95288_HQ208[SLW=0;VIO=0]
[Manufacturer]   Xilinx Inc.
[Package]
| variable   typ   min   max
R_pkg   0.106   0.102   0.110
L_pkg   8.900nH   7.900nH   9.900nH
C_pkg   1.650pF   1.500pF   1.800pF
[Pin]  signal_name   model_name   R_pin   L_pin   C_pin
io   iob   IO_00   NA   NA   NA
| End [Component] XC95288_HQ208[SLW=0;VIO=0]
|   Component XC95288_HQ208[SLW=0;VIO=1]
[Component]   XC95288_HQ208[SLW=0;VIO=1]
[Manufacturer]   Xilinx Inc.
[Package]
| variable   typ   min   max
R_pkg   0.106   0.102   0.110
L_pkg   8.900nH   7.900nH   9.900nH
C_pkg   1.650pF   1.500pF   1.800pF
[Pin]  signal_name   model_name   R_pin   L_pin   C_pin
io   iob   IO_01   NA   NA   NA
| End [Component] XC95288_HQ208[SLW=0;VIO=1]
|   Component XC95288_HQ208[SLW=1;VIO=0]
[Component]   XC95288_HQ208[SLW=1;VIO=0]
[Manufacturer]   Xilinx Inc.
[Package]
| variable   typ   min   max
R_pkg   0.106   0.102   0.110
L_pkg   8.900nH   7.900nH   9.900nH
C_pkg   1.650pF   1.500pF   1.800pF
[Pin]  signal_name   model_name   R_pin   L_pin   C_pin
io   iob   IO_10   NA   NA   NA
| End [Component] XC95288_HQ208[SLW=1;VIO=0]
|   Component XC95288_HQ208[SLW=1;VIO=1]
[Component]   XC95288_HQ208[SLW=1;VIO=1]
[Manufacturer]   Xilinx Inc.
[Package]
| variable   typ   min   max
R_pkg   0.106   0.102   0.110
L_pkg   8.900nH   7.900nH   9.900nH
C_pkg   1.650pF   1.500pF   1.800pF
[Pin]  signal_name   model_name   R_pin   L_pin   C_pin
io   iob   IO_11   NA   NA   NA
| End [Component] XC95288_HQ208[SLW=1;VIO=1]
| Models and submodels in the file (4): IO_00 (I/O), IO_10 (I/O), IO_01 (I/O), IO_11 (I/O)
